* Reference voltage and bias test at TT for 37 C
.include p18_cmos_models_tt.inc

VDD vdd 0 DC 1.8

* Reference Vref = VDD * R2/(R1+R2) = 115 mV
R1 vdd vref 1.465MEG
R2 vref 0   100k

* Bias M5 and RB
M5 vb vb vdd vdd PMOS L=1U W=1U
RB vb 0  1.2MEG

* Mirror M6 carries the same bias current
* VMEAS replaces the differential amplifier in this test
M6 tail vb vdd vdd PMOS L=1U W=1U
VMEAS tail 0 DC 0.6

.options temp=37
.op
.end
