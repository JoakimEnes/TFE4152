* Stack test for NMOS i TT
.include p18_cmos_models_tt.inc

VIN in 0 DC 0

* A: 1 NMOS L = 0.36u
VDD1 vdd1 0 DC 1.8
MP1  o1 in vdd1 vdd1 PMOS L=0.36U W=0.36U
MN1  o1 in 0    0    NMOS L=0.36U W=0.36U

* B: 1 NMOS, L = 0.72u som tilsvarer 2 * 0.36U
VDD2 vdd2 0 DC 1.8
MP2  o2 in vdd2 vdd2 PMOS L=0.36U W=0.36U
MN2  o2 in 0    0    NMOS L=0.72U W=0.36U

* C: 2 0.36U NMOS i serie
VDD3 vdd3 0 DC 1.8
MP3  o3  in vdd3 vdd3 PMOS L=0.36U W=0.36U
MN3a o3  in m3   0    NMOS L=0.36U W=0.36U
MN3b m3  in 0    0    NMOS L=0.36U W=0.36U

* D: 3 NMOS in series, 0.36u each total 1.08U
VDD4 vdd4 0 DC 1.8
MP4  o4  in vdd4 vdd4 PMOS L=0.36U W=0.36U
MN4a o4  in m4a  0    NMOS L=0.36U W=0.36U
MN4b m4a in m4b  0    NMOS L=0.36U W=0.36U
MN4c m4b in 0    0    NMOS L=0.36U W=0.36U

* E: 1 NMOS L = 1.08u tilsvarende 3 * 0.36
VDD5 vdd5 0 DC 1.8
MP5  o5 in vdd5 vdd5 PMOS L=0.36U W=0.36U
MN5  o5 in 0    0    NMOS L=1.08U W=0.36U

.options gmin=1e-15 temp=37
.op
.end
